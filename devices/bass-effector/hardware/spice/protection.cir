* 블록 A: 백투백 P-MOSFET 보호. VIN_RAW -18~+18V DC 스윕. 부하 40옴(9V에서 225mA)
.include models.inc
.include generated/block_A.cir
Vin vin_raw 0 DC 9
Rload v9 0 40
.dc Vin -18 18 0.1
.control
run
meas dc v9_rev18 FIND v(v9) AT=-18
meas dc v9_at9 FIND v(v9) AT=9
meas dc v9_at12 FIND v(v9) AT=12
meas dc v9_at12p5 FIND v(v9) AT=12.5
meas dc v9_at13 FIND v(v9) AT=13
meas dc v9_at15 FIND v(v9) AT=15
.endc
.end
