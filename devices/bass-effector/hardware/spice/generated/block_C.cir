* 자동 생성: gen_spice.py. 손으로 고치지 않는다.
* C. Seed3 VIN 필터와 전원 감시 (설계서 3.5절, 4.1절)
* BLOCKS 0df6b7d85cd821a3
R32 v9 seed_vin 3.3
C11 seed_vin 0 0.0001
C12 seed_vin 0 1e-07
R19 v9 vmon 47000
R20 vmon 0 10000
C14 vmon 0 1e-07
R21 vmon seed_a5_vmon 1000
