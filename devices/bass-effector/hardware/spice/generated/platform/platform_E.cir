* 자동 생성: gen_spice.py. 손으로 고치지 않는다.
* [메인] E. 출력단 (설계서 4.2절)
* BLOCKS f4b90206966105ab
C3 seed_audio_out1 out_in 1e-06
R6 out_in vbias 100000
XU1B out_in fb u1b_out vrail 0 opamp_model
R7 u1b_out fb 47000
R8 fb fb_c 10000
C4 fb_c 0 1e-05
R9 u1b_out out_r 100
C5 out_r out_c 1e-05
R10 out_c 0 100000
