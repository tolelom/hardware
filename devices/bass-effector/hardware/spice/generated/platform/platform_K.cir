* 자동 생성: gen_spice.py. 손으로 고치지 않는다.
* [조작부] K. 화면 Orient AFK320480A0-3.5INTH-ANO (설계서 3절, 모듈 데이터시트 V01 2절·도면)
* BLOCKS f4b90206966105ab
R60 seed_d16_display_bl_pwm display_blk 100
R61 display_blk 0 100000
C60 3v3_aux 0 1e-05
C61 3v3_aux 0 1e-07
