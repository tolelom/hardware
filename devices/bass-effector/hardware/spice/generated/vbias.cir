* 자동 생성: gen_spice.py. 손으로 고치지 않는다.
* 부분 묶음 vbias: R11, R12, C6. block_B와 같이 include하지 않는다
* BLOCKS 0df6b7d85cd821a3
R11 vrail vbias 10000
R12 vbias 0 10000
C6 vbias 0 0.0001
