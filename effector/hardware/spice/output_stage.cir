* 블록 E: 출력단 헤드룸. 모듈 출력 1Vrms(공통모드 1.65V)를 +15.1dB로. 레일 16.9V와 16.1V에서 클립 확인
.include opamp_rr.inc
.include generated/vbias.cir
.include generated/block_E.cir
Vrail vrail 0 16.9
Vseed seed_audio_out1 0 SIN(1.65 1.4142 1k)
Rjack out_c 0 10k
.ic v(vbias)=8.45 v(fb_c)=8.45 v(out_r)=8.45 v(out_in)=8.45
.tran 5u 400m
.control
run
meas tran out_pp PP v(out_c) from=380m to=400m
meas tran out_max MAX v(u1b_out) from=380m to=400m
meas tran out_min MIN v(u1b_out) from=380m to=400m
alter Vrail 16.1
run
meas tran out_pp_161 PP v(out_c) from=380m to=400m
meas tran out_max_161 MAX v(u1b_out) from=380m to=400m
meas tran out_min_161 MIN v(u1b_out) from=380m to=400m
.endc
.end
