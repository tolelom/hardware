* 극성 커패시터 C2, C4, C5, C6 양단 DC 전위(+ 쪽 - 쪽). 레일 16.6V(더블러 시뮬레이션 평균), 모듈 출력 DC 1.65V, 입력 무신호
.include opamp_rr.inc
.include generated/vbias.cir
.include generated/block_D.cir
.include generated/block_E.cir
Vrail vrail 0 16.6
Vseed seed_audio_out1 0 1.65
Rcodec seed_audio_in1 0 5k
.op
.control
run
let c2 = v(buf_out) - v(pad_in)
let c4 = v(fb_c)
let c5 = v(out_r) - v(out_c)
let c6 = v(vbias)
print c2 c4 c5 c6
.endc
.end
