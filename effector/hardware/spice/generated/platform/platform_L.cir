* 자동 생성: gen_spice.py. 손으로 고치지 않는다.
* [조작부] L. 보조 3.3V 강압 (설계서 4절·5.2절, TPS562201 데이터시트 SLVSD91D 7.2절)
* BLOCKS a52d60d17119c809
C30 v9 0 1e-05
C31 v9 0 1e-07
R80 v9 buck_en 100000
C32 buck_bst buck_sw 1e-07
LL10 buck_sw 3v3_buck 3.3e-06
C33 3v3_buck 0 2.2e-05
C34 3v3_buck 0 2.2e-05
R81 3v3_buck buck_fb 33200
R82 buck_fb 0 10000
RFB2 3v3_buck 3v3_aux 0.05
C35 3v3_aux 0 1e-05
