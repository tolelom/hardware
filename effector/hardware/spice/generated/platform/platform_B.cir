* 자동 생성: gen_spice.py. 손으로 고치지 않는다.
* [메인] B. LT1054 더블러와 아날로그 레일 (설계서 4.2절, 데이터시트 그림 20)
* BLOCKS f4b90206966105ab
XU2 v9 pump 0 lt1054
C16 v9 0 1e-05
C8 pumpx pump 1e-05
D1 v9 pumpx D1N5819
D2 pumpx vrail_raw D1N5819
C9 vrail_raw 0 0.0001
R16 vrail_raw vrail 10
C10 vrail 0 0.0001
C17 vrail 0 1e-07
R11 vrail vbias 10000
R12 vbias 0 10000
C6 vbias 0 0.0001
