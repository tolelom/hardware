* 자동 생성: gen_spice.py. 손으로 고치지 않는다.
* [메인] N. EXP 입력 (설계서 5.2절)
* BLOCKS a52d60d17119c809
R50 seed_3v3a exp_ring 4700
R51 seed_3v3a exp_tip 100000
R52 exp_tip seed_d15_exp_adc 1000
C50 seed_d15_exp_adc 0 1e-07
