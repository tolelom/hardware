* 자동 생성: gen_spice.py. 손으로 고치지 않는다.
* [메인] C. Seed3 VIN 필터와 전원 감시 (설계서 3.5절, 4.1절)
* BLOCKS 450e90e0df3202d6
R32 v9 seed_vin 3.3
C11 seed_vin 0 0.0001
C12 seed_vin 0 1e-07
R19 v9 vmon 47000
R20 vmon 0 10000
C14 vmon 0 1e-07
R21 vmon seed_d20_vmon_adc 1000
