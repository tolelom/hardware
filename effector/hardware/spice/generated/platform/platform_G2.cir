* 자동 생성: gen_spice.py. 손으로 고치지 않는다.
* [조작부] G2. 인코더 7개, 풋스위치 3개, LED 3개 (설계서 3절·5.2절)
* BLOCKS b4b31ea4aa3a4076
R98 3v3_aux u20_reset 10000
C93 3v3_aux 0 1e-07
R99 3v3_aux u21_reset 10000
C94 3v3_aux 0 1e-07
R96 3v3_aux seed_d11_i2c1_scl 4700
R97 3v3_aux seed_d12_i2c1_sda 4700
R100 3v3_aux enc1_a_raw 10000
R101 enc1_a_raw enc1_a 10000
C100 enc1_a 0 1e-08
R102 3v3_aux enc1_b_raw 10000
R103 enc1_b_raw enc1_b 10000
C101 enc1_b 0 1e-08
R104 3v3_aux enc2_a_raw 10000
R105 enc2_a_raw enc2_a 10000
C102 enc2_a 0 1e-08
R106 3v3_aux enc2_b_raw 10000
R107 enc2_b_raw enc2_b 10000
C103 enc2_b 0 1e-08
R108 3v3_aux enc3_a_raw 10000
R109 enc3_a_raw enc3_a 10000
C104 enc3_a 0 1e-08
R110 3v3_aux enc3_b_raw 10000
R111 enc3_b_raw enc3_b 10000
C105 enc3_b 0 1e-08
R112 3v3_aux enc4_a_raw 10000
R113 enc4_a_raw enc4_a 10000
C106 enc4_a 0 1e-08
R114 3v3_aux enc4_b_raw 10000
R115 enc4_b_raw enc4_b 10000
C107 enc4_b 0 1e-08
R116 3v3_aux enc5_a_raw 10000
R117 enc5_a_raw enc5_a 10000
C108 enc5_a 0 1e-08
R118 3v3_aux enc5_b_raw 10000
R119 enc5_b_raw enc5_b 10000
C109 enc5_b 0 1e-08
R120 3v3_aux enc6_a_raw 10000
R121 enc6_a_raw enc6_a 10000
C110 enc6_a 0 1e-08
R122 3v3_aux enc6_b_raw 10000
R123 enc6_b_raw enc6_b 10000
C111 enc6_b 0 1e-08
R124 3v3_aux nav_a_raw 10000
R125 nav_a_raw nav_a 10000
C112 nav_a 0 1e-08
R126 3v3_aux nav_b_raw 10000
R127 nav_b_raw nav_b 10000
C113 nav_b 0 1e-08
R90 3v3_aux seed_d22_fs1 10000
C90 seed_d22_fs1 0 1e-07
R93 seed_d25_led1 fsled1_a 470
D20 fsled1_a 0 DLEDR
R91 3v3_aux seed_d23_fs2 10000
C91 seed_d23_fs2 0 1e-07
R94 seed_d26_led2 fsled2_a 470
D21 fsled2_a 0 DLEDR
R92 3v3_aux seed_d24_fs3 10000
C92 seed_d24_fs3 0 1e-07
R95 seed_d27_led3 fsled3_a 470
D22 fsled3_a 0 DLEDR
