* 자동 생성: gen_spice.py. 손으로 고치지 않는다.
* [메인] F. K1 릴레이 바이패스와 구동 (설계서 3.4절, 5.4절)
* BLOCKS f9730b72d5d6f429
RK1_COIL v9 k1_coil 579
RK1_11_12 in_tip bypass {k1_on > 0.5 ? 1e+12 : 0.05}
RK1_11_14 in_tip in_a {k1_on > 0.5 ? 0.05 : 1e+12}
RK1_21_22 out_tip bypass {k1_on > 0.5 ? 1e+12 : 0.05}
RK1_21_24 out_tip out_c {k1_on > 0.5 ? 0.05 : 1e+12}
D4 k1_coil v9 D1N4148
Q4 k1_coil q4_b 0 Q2N3904
R17 seed_d0_k1_drive q4_b 2200
R18 q4_b 0 10000
