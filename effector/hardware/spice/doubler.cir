* 블록 B: LT1054 동작 모델 더블러의 레일 평균, 리플, 기동, 극성 C 전위. V9 9V, 레일 부하 2.8k(약 6mA)
* Vbias(R11·R12 10k, C6 100u)는 시정수 0.5s라 3초(6τ)까지 돌려 마지막 구간에서 평균·리플을 본다
.include models.inc
.include lt1054_behavioral.inc
.include generated/block_B.cir
V9 v9 0 9
Rload vrail 0 2800
.tran 0.5u 3
.control
run
meas tran rail_avg AVG v(vrail) from=2.9 to=3
meas tran rail_pp PP v(vrail) from=2.99 to=3
meas tran raw_pp PP v(vrail_raw) from=2.99 to=3
meas tran t_90 WHEN v(vrail)=15.2 RISE=1
let c8 = v(pumpx) - v(pump)
meas tran c8_avg AVG c8 from=2.9 to=3
meas tran c9_avg AVG v(vrail_raw) from=2.9 to=3
meas tran vbias_avg AVG v(vbias) from=2.9 to=3
let vbias_ratio = vbias_avg / rail_avg
print vbias_ratio
.endc
.end
