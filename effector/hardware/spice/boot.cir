* 부팅 과도: 레일이 20ms에 걸쳐 0에서 16.9V로, 모듈 출력 DC 1.65V가 100ms에 서는 경우 OUT_C(K1 NO 접점 쪽) 잔류 전압
.include opamp_rr.inc
.include generated/vbias.cir
.include generated/block_E.cir
Vrail vrail 0 PWL(0 0 20m 16.9)
Vseed seed_audio_out1 0 PWL(0 0 100m 1.65)
.tran 1m 15
.control
run
meas tran outc_max MAX v(out_c)
meas tran t_100mv WHEN v(out_c)=0.1 FALL=LAST
meas tran t_10mv WHEN v(out_c)=0.01 FALL=LAST
meas tran t_1mv WHEN v(out_c)=0.001 FALL=LAST
meas tran t_60dbu WHEN v(out_c)=0.00078 FALL=LAST
meas tran v_5s FIND v(out_c) AT=5
meas tran v_10s FIND v(out_c) AT=10
.endc
.end
